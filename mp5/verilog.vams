//Verilog-AMS HDL for "EE415", "dff_vams" "verilogams"

`include "constants.vams"
`include "disciplines.vams"
`timescale 100ps/10ps

module dff_vams (
d,
clk,
q,
qbar,
reset);
//--- Inputs ---//
input d, clk, reset;
logic d, clk, reset;
//--- Outputs --//
output q, qbar;
electrical q, qbar;
//--- Params --//
parameter real VDD=1.8;
integer state;

analog begin : main
  @(posedge(clk))
    state = (d > 0)&(reset > 0);

  V(q) <+ state*VDD;
  V(qbar) <+ VDD - V(q);

//  @(posedge(clk)) begin
//    // store d in q
//    if(reset==0) begin
//      if(d==0)
//	V(q) <+ VDD;
//      else
//	V(q) <+ 0.0;
//      V(qbar) <+ VDD - V(q);
//      end
//    else begin
//      V(q) <+ 0.0;
//      V(qbar) <+ VDD;
//      end
//  end

end

endmodule
