// VerilogA for EE415, DFF_VA, Veriloga

`include "constants.vams"
`include "disciplines.vams"

// signal flow model of d-flipflop
// with reset.
module dff_va (
 q	// output signal
,qb	// negation output
,d	// data input
,clk	// clock signal
,reset); // reset signal
  input clk,reset;	  // input vars
  output q,qb;		  // output vars
//  voltage q,qb,d,clk,reset;  // declare discipline
  electrical q,qb,d,clk,reset;  // declare discipline

  integer bin_state;	  // 1 if V is higher than VDD/2
			  // otherwise 0.

  parameter integer clk_dir=1 from [-1:1] exclude 0; // clock rise
  parameter real VDD=1.1 from (0:inf);		    // source is 1.1V
  parameter real Vthresh=1.1/2 from (0:inf);	    // digital threshold

  analog begin : main
    // update state @ +edge of clk
    @(cross (V(clk)-Vthresh, clk_dir))
      bin_state = (V(d) > Vthresh);
    V(q) <+ transition(bin_state * VDD,0,0); 	    // output curr state
    V(qb) <+ transition((1-bin_state) * VDD,0,0);   // output negation
  end

endmodule
